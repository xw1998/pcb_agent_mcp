one pole: 1 ohm reg, 1uF with 10 mohm ESR, 1 A step
Vref ref 0 0
R1 ref b 1
Rc b c 0.01
C1 c 0 1u
Iload b 0 PWL(0 0 1p 1)
.tran 1n 20u 0
.print tran v(b)
.end
